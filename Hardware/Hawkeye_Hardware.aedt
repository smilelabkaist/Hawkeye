# Ansys Electronics Desktop project, version 2021.2
materials:
  Rogers RO4003C: permittivity=3.55
  vacuum: permittivity=1

design 24GHz_Backscatter (HFSS, DrivenModal, model units mm)
options: Save_Adaptive_support_files
geometry:
  Region [vacuum] = region(absolute_offset=5mm on all sides)
  Antenna_array = imported_body()
  GND [vacuum] = imported_body()
  Silk_position = imported_body()
  PinHeader [non-model] = imported_body()
  Diode_eq_circuit [vacuum] = imported_body()
  Via = imported_body()
  Substrate [Rogers RO4003C] = imported_body()
